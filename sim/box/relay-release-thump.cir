* Audio board: how long after power-on before the bypass relays may be energised without a thump?
* Each output stage idles at the mid-rail VM. Its 22 uF coupling capacitor charges through the
* 100 k bleed on the stage's side of K1, so OUT_L starts near VM and decays. When K1 closes, whatever
* is left on OUT_L steps onto the output's tip. R47 is the bleed: 10 k as fitted (phase 2 had 100 k). The stage is taken as a follower of VM (no signal).
V5 v5a 0 PWL(0 0 10m 5)
R2 v5a mr1 10k
R3 mr1 0 10k
C10 mr1 0 100u
R4 mr1 mr2 10k
C11 mr2 0 100u
Ebuf stage 0 mr2 0 1
C46 stage n1 22u
R46 n1 outl 100
R47 outl 0 10k
.tran 10m 30
.control
run
foreach t 1 2 3 5 8 10 15 20 30
  meas tran v_at FIND v(outl) AT=$t
end
meas tran vm_end FIND v(mr2) AT=30
meas tran vpk MAX v(outl)
.endc
.end
